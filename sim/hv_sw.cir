* HV flyback switching deck (generated by sim/run_hv.py)
Vin vin 0 5.0
* gate drive: ton = 1.7 us at 250 kHz -> Ipk = Vin*ton/Lp = 0.181 A,
* the analytical design peak current (hv_design.py). Open-loop DCM
* flyback voltage is set by power balance into the load, NOT by the
* duty alone — this deck checks delivered-power class + ripple; the
* exact 420 V setpoint is the closed loop's job (deck 2 / LT3757).
Vgate gate 0 PULSE(0 5 0 20n 20n 1.7u 4.0u)
S1 vin sw gate 0 SWMOD
.model SWMOD SW(Ron=0.05 Roff=1e9 Vt=2.5)
Lp sw  0 47u
Ls 0 sec 18.8m
K1 Lp Ls 0.999
Rsnub sw sn 47
Csnub sn 0 470p
Dsec sec rect DSEC
.model DSEC D(IS=1e-12 RS=2 BV=1000 IBV=1e-6 CJO=4p)
Cout rect 0 47n
Rbleed rect 0 4.7Meg
Rfilt rect apd 10k
Cfilt apd 0 100n
Iload apd 0 200u
.ic v(rect)=380 v(apd)=380
.control
tran 8n 12m 0 25n uic
wrdata results/hv_sw.csv v(rect) v(apd)
.endc
.end
