* HV set-point network, C30737 fit (generated by sim/run_hv_clamp.py)
Vdac dac 0 0
Vref ref 0 1.6
Eservo hv 0 ref fb 1e6
R31 hv fb 7.68MEG
R32 fb 0 75.0k
R33 dac fb 140k
C34 fb 0 1n
.control
dc Vdac 0 2.5 0.25
wrdata results/hv_clamp_a.csv v(hv) v(fb)
quit
.endc
.end
