* SHDN divider, old (generated by sim/run_hv_clamp.py)
Vbus bus 0 5.0
R25 bus shdn 100k
R26 shdn 0 33k

.control
dc Vbus 4.75 5.25 0.25
wrdata results/hv_clamp_bold.csv v(shdn)
quit
.endc
.end
