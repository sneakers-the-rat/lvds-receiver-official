* TIA verification deck (generated by sim/run_tia.py)
.include sim/opa657_macromodel.lib
Vcc vcc 0 5.0
Vbias vbias 0 1.0
* APD: current source, Cd=1pF to AC ground (cathode HV is AC-grounded
* through its filter cap), dark resistance 100 Meg
Iph 0 inn dc 0 ac 1
Cd  inn 0 1.0p
Rd  inn 0 100Meg
* TIA: OPA657, IN+ at 1.0 V bias, Rf=3.3k, Cf=0.45p total
XU1 vbias inn vcc 0 out OPA657
Rf  out inn 3.3k
Cf  out inn 0.45p

.control
noise v(out) Iph dec 100 1e4 3e9
setplot noise1
wrdata results/tia_noise.csv onoise_spectrum
quit
.endc
.end
