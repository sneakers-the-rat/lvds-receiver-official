* HV flyback averaged closed-loop deck (generated by sim/run_hv.py)
* feedback divider 1/168: 420 V -> 2.50 V
Vref ref 0 PWL(0 0.893 99.99m 0.893 100m 2.5 220m 2.5)
Efb fb 0 rect 0 0.005952
Eerr err 0 ref fb 1.0
* Feedforward + proportional trim: Dff from the DCM energy balance
* Dff = sqrt( 2 Lp f Pload(Vt) / (eta Vin^2) ), Vt = 168 * V(ref),
* Pload(Vt) = Vt * (200 uA + Vt/4.7 Mohm).  Trim Kp = 0.02 per volt of
* fb error.  (The real LT3757 closes a current-mode loop on its FB pin;
* this averaged deck demonstrates setpoint regulation of the same plant.)
Eduty duty 0 value = {{min(max(sqrt(max(1.343 * (168*v(ref)) * (200e-6 + (168*v(ref))/4.7e6), 1e-4))  + 0.15*v(err), 0.05), 0.90)}}
* averaged DCM plant: I_charge = Pin(D)/Vout, Pin = Vin^2 D^2 eta/(2 Lp f)
Bplant 0 rect I = {{(25 * v(duty) * v(duty) * 0.70) / (2 * 47e-6 * 250e3) / max(v(rect), 1.0)}}
Cout rect 0 47n
Rbleed rect 0 4.7Meg
Iload rect 0 200u
.ic v(rect)=0
.control
tran 100u 220m 0 200u uic
wrdata results/hv_avg.csv v(rect) v(duty)
.endc
.end
