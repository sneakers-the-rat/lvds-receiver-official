* HV set-point worst corner (generated by sim/run_hv_clamp.py)
Vdac dac 0 0
Vref ref 0 1.631
Eservo hv 0 ref fb 1e6
R31 hv fb 7.68768MEG
R32 fb 0 74.925k
R33 dac fb 139.86k
Ifbx fb 0 100n
.control
op
wrdata results/hv_clamp_a2.csv v(hv)
quit
.endc
.end
